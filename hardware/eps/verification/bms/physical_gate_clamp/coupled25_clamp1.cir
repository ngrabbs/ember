* Coupled channel diagnostic, imposed drive; NOT pack-protection acceptance
.include "${FET_MODEL}"
Vcell cell 0 8.526
Rshunt sys 0 2m
Rreverse reverse_gate sys 1k
Xreverse gd reverse_gate port DMN62D2U
.include "${REVERSE_MODEL}"
Rcell cell cable 80m
Lcell cable raw 1u
Vch chgcmd 0 20.526
* Held BAT reservoir / stiff charge pump is an imposed stress fixture.
Voff off 0 PWL(0 1 0.00116 1 0.00126 0)
Bds dsgcmd 0 V=V(port)+0.4+V(off)*(20.126-V(port))
Rcg chgcmd gc 5.1k
Rdg dsgcmd gd 5.1k
Rgs1 gc raw 10meg
Rgs2 gd port 10meg
Xchg common gc raw csd18543q3a
Vids common dsgdrain 0
Xdsg dsgdrain gd port csd18543q3a
Rload port sys 4.263
Vfault command 0 PWL(0 0 1m 0 1.000001m 5)
Sfault port fault command 0 SHORT
Rfault fault sys 1m
.model SHORT SW(Ron=1m Roff=1e12 Vt=2.5)
* Equivalent capacitances of the two native 100 nF series pairs.
Cpair raw port 50n Rser=100m
Cport port sys 50n Rser=100m

.include "${CLAMP_MODEL}"
Vzc gc zc 0
Vzd gd zd 0
Xzc raw zc DI_BZT52C15
Xzd port zd DI_BZT52C15
.temp 25
.options plotwinsize=0 method=gear
.tran 0 3m 0 100n
.save V(sys) V(raw) V(common) V(dsgdrain) V(port) V(gc) V(gd) I(Vids) I(Lcell) I(Rcg) I(Rdg) I(Vzc) I(Vzd)
.end
