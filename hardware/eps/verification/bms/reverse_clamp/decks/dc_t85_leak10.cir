* Isolated clamp diagnostic; no BQ/main FET dynamics or qualified corners
.include "${DMN_MODEL}"
Vport port 0 0
Bdriver drive 0 V=max(V(port),0)+.4
Rdriver drive main_gate 5.1k
Roff main_gate port 10meg
Rclamp clamp_gate 0 1k
Ileak 0 clamp_gate 10u
Xclamp main_gate clamp_gate port DMN62D2U
.temp 85
.options plotwinsize=0
.dc Vport -8.526 8.526 .002
.save V(port) V(main_gate) V(clamp_gate) I(Bdriver)
.end
