* Unqualified passive interlock concept; stiffness/inrush fixture
.include vendor/sud50p08.lib
Vsource src 0 PWL(0 0 1m 0 1.001m 8.4)
Rsource src input .05
Lwire input din 1u
Cinput din 0 1u Rser=.05
Xpass din gate cs SUD50P08-25L
Xreverse out gate cs SUD50P08-25L
Rgs gate cs 220k
Dclamp gate cs DZ
Cgs gate cs 1e-07 Rser=1
Rpd gate pin 10k
Scontact pin 0 command 0 SWC
Vcommand command 0 PWL(0 0 50m 0 50.1m 1 150m 1 150.1m 0)
Cload out 0 100u Rser=.05
Rload out 0 10
.model DZ D(BV=10 IBV=5m RS=10 CJO=100p)
.model SWC SW(Ron=1 Roff=1e12 Vt=.5 Vh=-.1)
.options plotwinsize=0 reltol=.001 solver=alternate
.save V(out) V(cs) V(gate) V(command) I(Lwire) I(Xpass:R1) I(Xreverse:R1)
.tran 0 250m 0 5u
.meas tran off_hotplug_out MAX V(out) FROM=0 TO=49m
.meas tran startup_current MAX I(Lwire) FROM=50m TO=149m
.meas tran max_vgs MAX abs(V(gate,cs)) FROM=0 TO=250m
.meas tran vout_before_off FIND V(out) AT=149m
.meas tran vout_after_off FIND V(out) AT=230m
.end
