* Isolated device transient diagnostic; no complete interlock acceptance
.include "${PMOS_MODEL}"
Vsource src 0 8.4
Vgate gate src PWL(0 0 1m 0 3m -8.4 5m -8.4 7m 0)
Xdevice drain gate src SUD50P08-25L
Rload drain 0 10
Cload drain 0 100u Rser=.05
.options plotwinsize=0
.tran 0 9m 0 2u
.save V(drain) I(Vsource) V(gate,src)
.meas tran output_on FIND V(drain) AT=4m
.meas tran output_off FIND V(drain) AT=9m
.end
