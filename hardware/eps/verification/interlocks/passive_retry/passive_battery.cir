* Passive common-source pair diagnostic, one permitted source only
.include "${PMOS_MODEL}"
Vsource src 0 PWL(0 0 1m 0 1.001m 8.526 .3 8.526)
Rsource src input .05
Lwire input a 1u
Cinput a 0 1u Rser=.05
Xpass a gate cs SUD50P08-25L
Xreverse b gate cs SUD50P08-25L
Rgs gate cs 220k
Dclamp gate cs DZ
Cgs gate cs 100n Rser=10
Rpull gate contact 10k
Spermission contact 0 command 0 SWC
Vpermission command 0 PWL(0 0 50m 0 50.001m 1 200m 1 200.001m 0)
Cload b 0 142.7u Rser=.02
Rload b 0 10
.model DZ D(BV=10 IBV=5m RS=10 CJO=100p)
.model SWC SW(Ron=1 Roff=1e12 Vt=.5 Vh=.1)
.options plotwinsize=0
.tran 0 300m 0 5u
.save V(a) V(b) V(cs) V(gate) I(Vsource) I(Xpass:R1) I(Xreverse:R1)
.end
