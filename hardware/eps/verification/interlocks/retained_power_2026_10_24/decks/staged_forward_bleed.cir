* EXPERIMENT ONLY: independent bias, VOUT sensing common-source node
* Not a selected design or qualified manufacturer application
.lib "${LTSPICE_LIBRARY}/cmp/standard.mos"
.lib "${LTSPICE_LIBRARY}/sub/LTC4367.sub"
Vsource drive 0 PWL(0 0 1m 0 1.001m 8.526 .8 8.526)
Rsource drive input .05
Lwire input a 1u
Cinput a 0 1u Rser=.05
Vother unused 0 0
Runused unused 0 1meg
M1 a gate cs cs IRLR2908
M2 b gate cs cs IRLR2908
Dor1 a biasraw D100
Dor2 b biasraw D100
Spermission biasraw permission command 0 SWC
Rpermission permission 0 1meg
Dhold permission bias D100
Cbias bias 0 100n Rser=1
Ruvtop permission uv 100k
Ruvbottom uv 0 100k
Vmonbias bias vin 0
Vmonsense cs sense 0
Xcontroller 0 0 uv vin gate sense fault permission LTC4367
Rfault fault 0 1meg
Ccommon cs 0 1u Rser=1
Rgs gate cs 1meg
Rcsbleed cs 0 100k
Rbiasbleed bias 0 100k
Cgate gate 0 100n Rser=10
Cdirect b 0 22u Rser=.02
Rbatfet_proxy b sys .025
Csys sys 0 163.77u Rser=.02
Rload sys 0 10
Vcommand command 0 PWL(0 0 50m 0 50.1m 1 500m 1 500.1m 0)
.model D100 D(Is=1n N=1 Rs=2 Cjo=2p BV=100 Ibv=10u)
.model SWC SW(Ron=1 Roff=1e12 Vt=.5 Vh=-.05)
.options plotwinsize=0
.tran 0 .8 0 10u
.save V(a) V(b) V(cs) V(gate) V(bias) V(permission) V(uv) V(sys) I(Vsource) I(Vother) I(Vmonbias) I(Vmonsense) Id(M1) Id(M2)
.end
