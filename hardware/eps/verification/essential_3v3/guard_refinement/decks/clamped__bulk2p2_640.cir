* {'Lu': 2.2, 'Cu': 640, 'guard_r': 0.009, 'gate_clamp': True}; TYPICAL MODELS / IMPOSED PASSIVES, NO CIRCUIT ACCEPTANCE
.lib "${LTSPICE_LIBRARY}/sub/LTC4368-1.sub"
.lib "${TI_MODEL}"
Vsource drive 0 PWL(0 0 1m 0 2m 3.232799137558028 .4 3.232799137558028)
Rsource drive vin 0.001
Cpre vin 0 96u Rser=.01
Lguard vin pin 2.2u Rser=0.009
Cpin pin 0 100n Rser=.01
Vd1 pin drain1 0
Vd2 drain2 sense 0
XQ1 drain1 gate common csd18543q3a
XQ2 drain2 gate common csd18543q3a
Rsense sense out .015
Rgs gate common 10meg
Cgate gate gc 100n
Rgc gc 0 22k
Rov vin ov 58.8k
Rovb ov 0 10k
Ruv vin uv 47.5k
Ruvb uv 0 10k
Cretry retry 0 22n
Rfault vin fault 47k
Cout out 0 640u Rser=.01
Dgate 0 gate gate_negative_clamp
.model gate_negative_clamp D(Is=1n N=1.7 Rs=1 Cjo=2p Bv=85 Ibv=.1u)
Bload out 0 I=min(max(V(out),0)/.1,if(time<.25,.2,if(time>.29,2,2)))
Xcontroller vin uv ov retry 0 vin fault out sense gate LTC4368-1
.temp 27
.options plotwinsize=0
.tran 0 .4 0 2u
.save V(vin) V(pin) V(out) V(common) V(gate) V(retry) V(uv) V(ov) V(fault) V(gc) I(Rsense) I(Lguard) I(Vd1) I(Vd2)
.end
