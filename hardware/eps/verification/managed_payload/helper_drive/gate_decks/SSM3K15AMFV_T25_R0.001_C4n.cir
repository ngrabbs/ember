* Helper-only charge-discharge benchmark; no full eFuse or EPS model
.lib "/Users/nick/Library/Application Support/LTspice/lib/sub/Contrib/Toshiba/LVMOS/SSM3K15AMFV_G0_00_enc.lib"
Vpre pre 0 14
Vinit init 0 PWL(0 1 9u 1 9.001u 0 30u 0)
Spre pre bg init 0 pre
.model pre SW(Ron=1 Roff=1e12 Vt=.5)
Ibias 0 bg 23u
Rbleed bg 0 800k
Cmain bg 0 4e-09
Vcmd drv 0 PWL(0 0 13u 0 13.01u 3 30u 3)
Rdrv drv hg 10
Croute hg 0 10p
Roff bg hd 0.001
Xhelper hd hg 0 SSM3K15AMFV_G0_00
.temp 25
.options plotwinsize=0 method=gear
.tran 0 30u 0 2e-09
.save V(bg) V(hg) V(hd) I(Roff) I(Rdrv)
.end
